* four_bit_counter.cir
* Generated from a PyRTL working block.
* Transistor-level cells are embedded at the end of this file.
* Supported: combinational logic, muxes, arithmetic, comparisons, and registers.
* Registers are positive-edge-triggered and share CLK.
* Suggested plot nodes: V(COUNT_0), V(COUNT_1), V(COUNT_2), V(COUNT_3), V(CLK)

* 1) POWER SUPPLY

VDD_SOURCE VDD 0 5

* Shared positive-edge clock
VCLK CLK 0 PULSE(0 5 5u 50n 50n 5u 10u)
VINIT INIT 0 PWL(0 5 6u 5 6.05u 0)

* 2) INPUT VOLTAGE PULSES

* 3) GENERATED CIRCUIT

EWIRE_1 COUNT_0 0 counter_0 0 1
EWIRE_2 COUNT_1 0 counter_1 0 1
EWIRE_3 COUNT_2 0 counter_2 0 1
EWIRE_4 COUNT_3 0 counter_3 0 1
XREG_INIT_5 tmp3_0 0 INIT __counter_dinit_0_1 VDD 0 MUX2
XDFF_counter_0_6 __counter_dinit_0_1 counter_0 CLK VDD 0 DFF
.ic V(counter_0)=0
XREG_INIT_7 tmp3_1 0 INIT __counter_dinit_1_2 VDD 0 MUX2
XDFF_counter_1_8 __counter_dinit_1_2 counter_1 CLK VDD 0 DFF
.ic V(counter_1)=0
XREG_INIT_9 tmp3_2 0 INIT __counter_dinit_2_3 VDD 0 MUX2
XDFF_counter_2_10 __counter_dinit_2_3 counter_2 CLK VDD 0 DFF
.ic V(counter_2)=0
XREG_INIT_11 tmp3_3 0 INIT __counter_dinit_3_4 VDD 0 MUX2
XDFF_counter_3_12 __counter_dinit_3_4 counter_3 CLK VDD 0 DFF
.ic V(counter_3)=0
ESELECT_13 tmp0_0 0 0 0 1
ESELECT_14 tmp0_1 0 0 0 1
ESELECT_15 tmp0_2 0 0 0 1
ECONCAT_16 tmp1_0 0 VDD 0 1
ECONCAT_17 tmp1_1 0 tmp0_0 0 1
ECONCAT_18 tmp1_2 0 tmp0_1 0 1
ECONCAT_19 tmp1_3 0 tmp0_2 0 1
XADD_0_20 counter_0 tmp1_0 0 tmp2_0 __ADD_carry_0_5 VDD 0 FULLADDER
XADD_1_21 counter_1 tmp1_1 __ADD_carry_0_5 tmp2_1 __ADD_carry_1_6 VDD 0 FULLADDER
XADD_2_22 counter_2 tmp1_2 __ADD_carry_1_6 tmp2_2 __ADD_carry_2_7 VDD 0 FULLADDER
XADD_3_23 counter_3 tmp1_3 __ADD_carry_2_7 tmp2_3 __ADD_carry_3_8 VDD 0 FULLADDER
XADD_4_24 0 0 __ADD_carry_3_8 tmp2_4 __ADD_carry_4_9 VDD 0 FULLADDER
ESELECT_25 tmp3_0 0 tmp2_0 0 1
ESELECT_26 tmp3_1 0 tmp2_1 0 1
ESELECT_27 tmp3_2 0 tmp2_2 0 1
ESELECT_28 tmp3_3 0 tmp2_3 0 1

* Output loads

CLOAD_COUNT_0 COUNT_0 0 10f
RLOAD_COUNT_0 COUNT_0 0 100Meg
CLOAD_COUNT_1 COUNT_1 0 10f
RLOAD_COUNT_1 COUNT_1 0 100Meg
CLOAD_COUNT_2 COUNT_2 0 10f
RLOAD_COUNT_2 COUNT_2 0 100Meg
CLOAD_COUNT_3 COUNT_3 0 10f
RLOAD_COUNT_3 COUNT_3 0 100Meg

* 4) SIMULATION COMMAND

.options reltol=0.01 abstol=1n vntol=1m method=gear gshunt=1e-12 cshunt=1f
.tran 0 100u 0 100n uic
.save V(COUNT_0) V(COUNT_1) V(COUNT_2) V(COUNT_3) V(CLK) V(INIT)

* 5) TRANSISTOR MODELS

* Conservative long-channel dimensions are used with these Level-1 models.
.model NMOS NMOS (LEVEL=1 VTO=0.7 KP=120u LAMBDA=0.02)
.model PMOS PMOS (LEVEL=1 VTO=-0.7 KP=60u LAMBDA=0.02)

* 6) TRANSISTOR-LEVEL STANDARD-CELL LIBRARY

* Inverter
* Pin order: IN OUT VDD VSS
.subckt INV IN OUT VDD VSS
MP1 OUT IN VDD VDD PMOS W=80u L=4u
MN1 OUT IN VSS VSS NMOS W=40u L=4u
.ends INV

* Two-input NAND. Series NMOS devices are widened.
* Pin order: A B Y VDD VSS
.subckt NAND2 A B Y VDD VSS
MP1 Y A VDD VDD PMOS W=80u L=4u
MP2 Y B VDD VDD PMOS W=80u L=4u
MN1 Y A NINT VSS NMOS W=80u L=4u
MN2 NINT B VSS VSS NMOS W=80u L=4u
.ends NAND2

* AND = NAND + inverter
* Pin order: A B Y VDD VSS
.subckt AND2 A B Y VDD VSS
XNAND A B N_NAND VDD VSS NAND2
XINV N_NAND Y VDD VSS INV
.ends AND2

* Two-input NOR. Series PMOS devices are widened.
* Pin order: A B Y VDD VSS
.subckt NOR2 A B Y VDD VSS
MP1 NPU A VDD VDD PMOS W=160u L=4u
MP2 Y B NPU VDD PMOS W=160u L=4u
MN1 Y A VSS VSS NMOS W=40u L=4u
MN2 Y B VSS VSS NMOS W=40u L=4u
.ends NOR2

* OR = NOR + inverter
* Pin order: A B Y VDD VSS
.subckt OR2 A B Y VDD VSS
XNOR A B N_NOR VDD VSS NOR2
XINV N_NOR Y VDD VSS INV
.ends OR2

* XOR from four NAND gates
* Pin order: A B Y VDD VSS
.subckt XOR2 A B Y VDD VSS
XN1 A B N1 VDD VSS NAND2
XN2 A N1 N2 VDD VSS NAND2
XN3 B N1 N3 VDD VSS NAND2
XN4 N2 N3 Y VDD VSS NAND2
.ends XOR2

* XNOR = XOR + inverter
* Pin order: A B Y VDD VSS
.subckt XNOR2 A B Y VDD VSS
XXOR A B N_XOR VDD VSS XOR2
XINV N_XOR Y VDD VSS INV
.ends XNOR2

* 2:1 multiplexer
* Y=A when S=0; Y=B when S=1
* Pin order: A B S Y VDD VSS
.subckt MUX2 A B S Y VDD VSS
XINV_S S S_B VDD VSS INV
XAND_A A S_B N_A VDD VSS AND2
XAND_B B S N_B VDD VSS AND2
XOR_OUT N_A N_B Y VDD VSS OR2
.ends MUX2

* Full adder
* Pin order: A B CIN SUM COUT VDD VSS
.subckt FULLADDER A B CIN SUM COUT VDD VSS
XXOR1 A B P VDD VSS XOR2
XXOR2 P CIN SUM VDD VSS XOR2
XAND1 A B C1 VDD VSS AND2
XAND2 P CIN C2 VDD VSS AND2
XOR1 C1 C2 COUT VDD VSS OR2
.ends FULLADDER

* Fast positive-edge-triggered DFF using LTspice's native digital device.
* External pin order remains: D Q CLK VDD VSS
*
* VDD remains in the subcircuit interface so the existing converter
* does not need any changes, although the native DFLOP does not use it.
.subckt DFF D Q CLK VDD VSS

* Native DFLOP pin order:
* D+ D- CLK PRE CLR QBAR Q COMMON
*
* Nonzero delay prevents zero-delay feedback races in counters.
A_DFF D VSS CLK VSS VSS VSS Q VSS DFLOP Vhigh=5 Vlow=0 Ref=2.5 Td=5n Trise=1n Tfall=1n

.ends DFF

.end
